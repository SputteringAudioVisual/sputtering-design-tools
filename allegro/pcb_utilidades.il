; Load this file, then: skill pcbCargar("C:/SPB_Data/pcbenv/pcb_tools")
procedure(pcbCargar(carpeta)
  prog((resultado)
    foreach(archivo '("pcb_config.il" "pcb_anchos.il" "pcb_textos.il" "pcb_mascara.il" "pcb_fabricacion.il")
      resultado = errset(load(strcat(carpeta "/" archivo)) t)
      unless(resultado && car(resultado)
        error("PCB: no se pudo cargar %s. Revisa la ruta y los archivos." archivo))
    )
    printf("PCB: utilidades cargadas. Comienza por los comandos de auditoria.\n")
    return(t)
  )
)
