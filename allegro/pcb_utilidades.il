; Load this file, then: skill pcbCargar("C:/SPB_Data/pcbenv/pcb_tools")
procedure(pcbCargar(carpeta)
  prog((resultado)
    pcbToolsRoot = if(rexMatchp("^[A-Za-z]:/" carpeta) || rexMatchp("^/" carpeta)
      then carpeta else strcat(getWorkingDir() "/" carpeta))
    pcbToolsVersion = "0.2.0"
    load(strcat(pcbToolsRoot "/pcb_config.il"))
    load(strcat(pcbToolsRoot "/pcb_proyecto.il"))
    when(isFile(strcat(pcbToolsRoot "/pcb_local.il"))
      load(strcat(pcbToolsRoot "/pcb_local.il")))
    foreach(archivo '("pcb_anchos.il" "pcb_textos.il" "pcb_mascara.il" "pcb_fabricacion.il" "pcb_compat.il")
      resultado = errset(load(strcat(carpeta "/" archivo)) t)
      unless(resultado && car(resultado)
        error("PCB: no se pudo cargar %s. Revisa la ruta y los archivos." archivo))
    )
    pcbUtilidadesInfo()
    return(t)
  )
)

procedure(pcbUtilidadesInfo()
  printf("PCB: utilidades %s cargadas desde %s\n" pcbToolsVersion pcbToolsRoot)
  printf("PCB: comandos pcb_textos / pcb_mascara / pcb_anchos / pcb_fab_exportar.\n")
  printf("PCB: primero usa sus auditorias. Cargar no modifica la placa.\n")
  t
)
axlCmdRegister("pcb_utilidades_info" 'pcbUtilidadesInfo ?cmdType "general")
