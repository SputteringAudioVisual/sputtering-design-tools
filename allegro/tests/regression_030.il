; Native regression. Run ONLY on a disposable copy with ordinary vias,
; at least one missing RefDes and an OVAL SLOT fixture. No PCB is distributed.
procedure(pcbRegAssert(value message)
  unless(value error("REGRESSION: %s" message))
  printf("REGRESSION PASS: %s\n" message)
)
procedure(pcbRegPins()
  let((rows ps)
    foreach(item pcbMaskItems()
      when(cadr(item)=='pin
        ps=car(item)->definition
        rows=cons(list(car(item)->xy car(item)->name ps->name
          pcbMaskDrillSignature(ps)
          foreach(mapcar p ps->pads list(p->layer p->type p->figureName p->offset p->bBox))) rows)))
    rows))
procedure(pcbRegTexts()
  let((rows orient)
    foreach(sym axlDBGetDesign()->symbols
      foreach(txt axlDBGetAttachedText(sym)
        orient=axlTextOrientationCopy(txt)
        rows=cons(list(txt->text txt->xy txt->layer orient->textBlock orient->rotation orient->mirrored orient->justify) rows)))
    rows))
procedure(pcbRegFailVias() pcbViasWorker() error("EXPECTED_TEST_FAILURE: rollback vias"))
procedure(pcbRegFailRefs() pcbSilkFaltantesWorker() error("EXPECTED_TEST_FAILURE: rollback refs"))
procedure(pcbRegFailFilms() pcbFabConfigurarWorker() error("EXPECTED_TEST_FAILURE: rollback films"))
procedure(pcbRegressionRun()
  prog((pins texts vias refs films path units power tx ps slots minValue maxValue prop result beforeWidths missing orient)
    pins=pcbRegPins() texts=pcbRegTexts() path=pcbProyectoArchivo()
    vias=pcbViasAuditar() refs=pcbSilkFaltantesAuditar()
    films=axlGetParam("artwork")->groupMembers
    slots=pcbFabRanuras()
    pcbRegAssert(cadr(vias)>0 && car(refs)>cadr(refs) && car(slots)>0 "fixture includes wrong vias, missing references and plated slots")
    pcbRegAssert(pcbAnchosAuditar() && pcbAnchosLastRuleWarnings==0 "preserved physical widths checked on every routing layer")
    pcbRegAssert(equal(pins pcbRegPins()) && equal(texts pcbRegTexts()) "audits do not change pins or texts")
    ps=car(setof(p axlDBGetDesign()->padstacks equal(p->holeType "OVAL SLOT")))
    pcbRegAssert(ps && !pcbMaskNeeds(ps 'pin) "identical OBLONG_X soldermask accepted")
    pcbRegAssert(pcbViasPadEspecial(ps) "slot padstack rejected as ordinary via")
    pcbMaskMarginMM=0.05
    pcbRegAssert(pcbMaskNeeds(ps 'pin) "oblong needs manual review for positive expansion")
    pcbMaskMarginMM=0.0
    pcbRegAssert(!errset(pcbMaskClone(ps 'pin) nil) "slot drill is never reconstructed by simple mask cloner")
    pcbRegAssert(equal(pins pcbRegPins()) "slot audit does not alter padstack geometry")
    missing=car(setof(comp axlDBGetDesign()->components comp->symbol &&
      !setof(txt axlDBGetAttachedText(comp->symbol) equal(txt->text comp->name))))
    tx=axlDBTransactionStart()
    orient=make_axlTextOrientation(?textBlock "1" ?rotation 0.0 ?mirrored nil ?justify "center")
    pcbRegAssert(axlDBCreateText(missing->name 20:20 orient "BOARD GEOMETRY/SILKSCREEN_TOP" nil) "create unrelated RefDes fixture")
    pcbRegAssert(cadr(pcbSilkFaltantesAuditar())==cadr(refs)+1 "unattached matching RefDes prevents duplicate recreation")
    axlDBTransactionRollback(tx)
    power=car(setof(net axlDBGetDesign()->nets pcbEsRedPotencia(net->name)))
    prop=axlDBGetProperties(power)
    tx=axlDBTransactionStart()
    pcbRegAssert(axlCNSCreate('physical "TEST_WRONG_WIDTH" nil) "create test width rule")
    axlCNSSetPhysical("TEST_WRONG_WIDTH" nil 'width_min "0.250 MM")
    axlCNSSetPhysical("TEST_WRONG_WIDTH" nil 'width_max "0.250 MM")
    axlDBAddProp(power list("PHYSICAL_CONSTRAINT_SET" "TEST_WRONG_WIDTH"))
    pcbRegAssert(pcbAnchosRevisarReglas(power)>0 "foreign rule with wrong width is reported")
    axlDBTransactionRollback(tx)
    power=car(setof(net axlDBGetDesign()->nets pcbEsRedPotencia(net->name)))
    pcbRegAssert(equal(prop axlDBGetProperties(power)) "test constraint assignment rolled back")
    pcbRegAssert(!pcbProyectoAplicar("prueba_vias" 'pcbRegFailVias) "injected via failure is caught")
    pcbRegAssert(equal(vias pcbViasAuditar()) && equal(pins pcbRegPins()) "all via changes roll back without changing pins")
    pcbRegAssert(!pcbProyectoAplicar("prueba_refs" 'pcbRegFailRefs) "injected reference failure is caught")
    pcbRegAssert(equal(refs pcbSilkFaltantesAuditar()) && equal(texts pcbRegTexts()) "all created references roll back")
    pcbRegAssert(!pcbProyectoAplicar("prueba_films" 'pcbRegFailFilms) "injected film failure is caught")
    pcbRegAssert(equal(films axlGetParam("artwork")->groupMembers) "film parameters roll back")
    pcbRegAssert(pcbViasNormalizar()==cadr(vias) "only planned existing vias changed")
    pcbRegAssert(equal(pins pcbRegPins()) "component pins and slots untouched")
    pcbRegAssert(cadr(pcbViasAuditar())==0 && pcbViasNormalizar()==t "via normalization is idempotent")
    pcbRegAssert(pcbSilkRecrear()==car(refs)-cadr(refs) "only missing references recreated")
    pcbRegAssert(equal(pcbSilkFaltantesAuditar() '(0 0)) && pcbSilkRecrear()==t "reference recreation is idempotent")
    foreach(row texts pcbRegAssert(member(row pcbRegTexts()) "existing text preserved"))
    pcbRegAssert(equal(slots pcbFabRanuras()) "plated slot count preserved")
    pcbRegAssert(!pcbFabExportar() "export refused before shape/DRC refresh")
    pcbRegAssert(numberp(pcbRevisionActualizar()) && axlDBDynamicShapes(nil)==0 "shape and DRC refresh complete")
    pcbRegAssert(!pcbRevisionPendiente() "session review requirement cleared only after refresh")
    pcbRegAssert(pcbFabConfigurar() && pcbFabFilmsCorrectos() "exactly seven films configured")
    pcbRegAssert(pcbFabConfigurar() && length(axlGetParam("artwork")->groupMembers)==7 "film configuration is idempotent")
    result=pcbFabExportar()
    pcbRegAssert(result && isFile(result) "complete ZIP including plated slots")
    pcbRegAssert(equal(path pcbProyectoArchivo()) "all backups preserve active project path")
    pcbRegAssert(equal(pins pcbRegPins()) "final component padstacks match input")
    pcbRegAssert(pcbCargar(pcbToolsRoot) "repeat load with unchanged files")
    axlSaveDesign(?design "validated.brd" ?noMru t ?noConfirm t ?writeModel t)
    printf("REGRESSION_030_ALL_PASS\n")
    return(t)))
