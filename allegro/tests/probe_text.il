procedure(pcbProbe(tag valor)
  let((f)
    f=outfile("probe.txt" "a") fprintf(f "%s %L\n" tag valor) close(f)
  )
)
pcbProbe("BEGIN" t)
procedure(pcbProbeRun()
  prog((b param)
    load("package/pcb_utilidades.il")
    pcbCargar("package")
    pcbProbe("TEXT_FIRST" pcbSilkAplicar())
    b=pcbSilkCrearBloque()
    pcbProbe("BLOCK" b)
    param=axlGetParam(sprintf(nil "paramTextBlock:%d" b))
    pcbProbe("STYLE" param->??)
    pcbProbe("TEXT_SECOND" pcbSilkAplicar())
    pcbProbe("BLOCK_SECOND" pcbSilkCrearBloque())
    pcbTextHeightMM=1.20
    pcbProbe("BLOCK_CONFIGURED" pcbSilkCrearBloque())
    pcbProbe("DONE" t)
    return(t)
  )
)
pcbProbe("RESULT" errset(pcbProbeRun() t))
