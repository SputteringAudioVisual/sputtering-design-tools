; Run ONLY on a disposable board copy, from its own working directory.
; Put all package .il files in ./package before loading this test.
procedure(pcbTestLog(tag valor)
  let((f)
    f = outfile("validation.txt" "a")
    fprintf(f "%s %L\n" tag valor)
    close(f)
  )
)
procedure(pcbTestAssert(valor mensaje)
  unless(valor error("TEST: %s" mensaje))
)
procedure(pcbTestRun()
  prog((audit afterMask firstNet originalProp originalDefault bloque1 bloque2 resultado cwd ncd estados)
    load("package/pcb_utilidades.il")
    pcbTestAssert(pcbCargar("package") "carga")
    pcbTestLog("LOAD" t)
    pcbTestLog("NET_PROPERTIES" axlDBGetProperties(car(axlDBGetDesign()->nets)))
    audit = pcbMaskAudit()
    pcbTestLog("MASK_BEFORE" audit)
    pcbTestAssert(pcbMaskApply() "mascara")
    afterMask = pcbMaskAudit()
    pcbTestAssert(nth(2 afterMask) == 0 && nth(3 afterMask) == 0 "mascara pendiente")
    pcbTestLog("MASK_AFTER" afterMask)
    pcbTestAssert(pcbMaskApply() "mascara idempotente")
    pcbTestAssert(equal(afterMask pcbMaskAudit()) "auditoria idempotente")
    pcbTestLog("MASK_IDEMPOTENT" t)
    pcbTestAssert(pcbSilkAuditar() "auditoria textos")
    pcbTestAssert(pcbSilkAplicar() "textos")
    bloque1 = pcbSilkCrearBloque()
    pcbTestAssert(pcbSilkAplicar() "textos segunda ejecucion")
    pcbTestAssert(bloque1 == pcbSilkCrearBloque() "reutilizacion bloque")
    pcbTextHeightMM = 1.20
    bloque2 = pcbSilkCrearBloque()
    pcbTestAssert(bloque1 != bloque2 "configuracion nuevo bloque")
    pcbTextHeightMM = 0.79
    pcbTestLog("TEXT_CONFIG_AND_REPEAT" t)
    originalDefault = axlCNSGetPhysical("" nil 'width_min)
    firstNet = car(axlDBGetDesign()->nets)
    unless(member("TEST_CUSTOM" axlCnsList('physical)) axlCNSCreate('physical "TEST_CUSTOM" nil))
    pcbTestAssert(axlDBAddProp(firstNet list("PHYSICAL_CONSTRAINT_SET" "TEST_CUSTOM")) "regla propia")
    pcbTestLog("CUSTOM_PROPERTIES" axlDBGetProperties(firstNet))
    pcbTestAssert(pcbAnchosAuditar() "auditoria anchos")
    pcbTestAssert(pcbAplicarAnchos() "anchos")
    pcbTestLog("VIA_PADS" foreach(mapcar pad axlDBFindByName('padstack "PCB_VIA_SIG_600_300")->pads
      list(pad->layer pad->type pad->figureName pad->bBox)))
    pcbTestLog("CUSTOM_AFTER" axlDBGetProperties(firstNet))
    pcbTestAssert(equal(originalDefault axlCNSGetPhysical("" nil 'width_min)) "DEFAULT conservado")
    pcbTestAssert(pcbAnchosReglaAjena(firstNet nil) "regla especial conservada")
    pcbTestAssert(pcbAplicarAnchos() "anchos segunda ejecucion")
    pcbTestLog("WIDTH_CONFIG_AND_REPEAT" t)
    pcbTestLog("FAB_AUDIT" pcbFabAuditar())
    pcbTestAssert(pcbFabConfigurar() "films")
    cwd = getWorkingDir()
    ncd = getShellEnvVar("NCDPATH")
    resultado = pcbFabExportar()
    pcbTestLog("FAB_EXPORT" resultado)
    pcbTestAssert(resultado && isFile(resultado) && equal(resultado pcbFabLastZip) "ZIP versionado")
    pcbTestAssert(equal(cwd getWorkingDir()) && equal(ncd getShellEnvVar("NCDPATH")) "entorno restaurado")
    estados = pcbFabLastResult
    pcbTestLog("FAB_STATUS" estados)
    pcbTestAssert(estados && member(cadr(estados) '(t 1)) && member(nth(2 estados) '(t 1)) "exportacion sin errores")
    foreach(film '("COPPER_TOP" "COPPER_BOTTOM" "MASK_TOP" "MASK_BOTTOM" "OUTLINE" "SILK_TOP" "SILK_BOTTOM")
      pcbTestAssert(isFile(strcat(car(estados) "/" film ".art")) "falta un film"))
    pcbTestAssert(axlSaveDesign(?design "validated.brd" ?noMru t ?noConfirm t) "guardar copia")
    pcbTestLog("ALL_PASS" t)
    return(t)
  )
)
pcbTestLog("RESULT" errset(pcbTestRun() t))
