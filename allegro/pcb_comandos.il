; Route the public names through Allegro's built-in SKILL command, matching
; the direct calls used to diagnose a silent GUI callback in 17.2.
procedure(pcbInstalarComandos()
  prog((nombre llamada intentos)
    foreach(entrada '(
      ("pcb_info" "pcbUtilidadesInfo")
      ("pcb_recargar" "pcbRecargar")
      ("pcb_revision_actualizar" "pcbRevisionActualizar")
      ("pcb_utilidades_info" "pcbUtilidadesInfo")
      ("pcb_textos_auditar" "pcbSilkAuditar")
      ("pcb_textos" "pcbSilkAplicar")
      ("pcb_textos_faltantes_auditar" "pcbSilkFaltantesAuditar")
      ("pcb_textos_recrear" "pcbSilkRecrear")
      ("pcb_anchos_auditar" "pcbAnchosAuditar")
      ("pcb_anchos" "pcbAplicarAnchos")
      ("pcb_vias_auditar" "pcbViasAuditar")
      ("pcb_vias_normalizar" "pcbViasNormalizar")
      ("pcb_mascara_revisar" "pcbMaskAudit")
      ("pcb_mascara_auditar" "pcbMaskAudit")
      ("pcb_mascara" "pcbMaskApply")
      ("pcb_fab_auditar" "pcbFabAuditar")
      ("pcb_fab_configurar" "pcbFabConfigurar")
      ("pcb_fab_exportar" "pcbFabExportar")
      ("fx_textos_auditar" "pcbSilkAuditar")
      ("fx_textos" "pcbSilkAplicar")
      ("fx_anchos_auditar" "pcbAnchosAuditar")
      ("fx_anchos" "pcbAplicarAnchos")
      ("fx_mascara_revisar" "pcbMaskAudit")
      ("fx_mascara_auditar" "pcbMaskAudit")
      ("fx_mascara" "pcbMaskApply")
      ("fx_fab_auditar" "pcbFabAuditar")
      ("fx_fab_configurar" "pcbFabConfigurar")
      ("fx_fab_exportar" "pcbFabExportar"))
      nombre=car(entrada)
      intentos=0
      ; Remove stale 0.2.0 command registrations before defining an alias.
      while(assoc(nombre axlCmdList())
        intentos=intentos+1
        when(intentos>20 error("PCB: no se pudo retirar el registro antiguo de %s." nombre))
        unless(axlCmdUnregister(nombre)
          error("PCB: no se pudo retirar el registro antiguo de %s." nombre)))
      llamada=sprintf(nil "skill %s()" cadr(entrada))
      unless(axlSetAlias(nombre llamada) && equal(axlGetAlias(nombre) llamada)
        error("PCB: no se pudo configurar el comando %s." nombre))
    )
    return(t)
  )
)
